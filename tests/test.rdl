reg example {
    field {
        sw = rw;
        hw = r;
        desc = "An example field";
    } f1[7:0];
};